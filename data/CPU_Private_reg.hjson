// Copyright lowRISC contributors.
// Licensed under the Apache License, Version 2.0, see LICENSE for details.
// SPDX-License-Identifier: Apache-2.0
{ name: "CPU_Private",
  clock_primary: "clk_i",
  bus_interfaces: [
    { protocol: "reg_iface", direction: "device" }
  ],
  regwidth: "32",
  registers: [
    { name:     "Core_Id",
      desc:     "Core_Id",
      swaccess: "ro",
      hwaccess: "hwo",
      fields: [
        { bits: "2:0", name: "Core_Id", desc: "Core_Id" }
      ]
    },
    { name:     "Hart_intc_ack",
      desc:     "ACK of Sync Interrupt",
      swaccess: "rw",
      hwaccess: "hro",
      fields: [
        { bits: "0", name: "Hart_intc_ack", desc: "Hart_intc_ack" }
      ]
    }
    { name:     "Breakpoint_Sim",
      desc:     "Breakpoint_Sim",
      swaccess: "rw",
      hwaccess: "none",
      fields: [
        { bits: "0", name: "Breakpoint", desc: "Breakpoint" }
      ]
    }   

   ]
}
